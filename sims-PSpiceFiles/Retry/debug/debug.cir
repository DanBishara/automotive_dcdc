** Profile: "Retry-debug"  [ C:\Users\WFE\Documents\automotive_dcdc\sims-pspicefiles\retry\debug.sim ]

** Creating circuit file "debug.cir"
** WARNING: THIS AUTOMATICALLY GENERATED FILE MAY BE OVERWRITTEN BY SUBSEQUENT SIMULATIONS

*Libraries:
* Profile Libraries :
* Local Libraries :
* From [PSPICE NETLIST] section of C:\cds_spb_home\cdssetup\OrCAD_PSpiceTIPSpice_Install\23.1.0\PSpice.ini file:
.lib "nom_pspti.lib"
.lib "nom.lib"

*Analysis directives:
.TRAN  0 0.5 0
.OPTIONS ADVCONV
.OPTIONS FILEMODELSEARCH
.PROBE64 N([VIN])
.PROBE64 N([VOUT])
.PROBE64 I(L_L1)
.PROBE64 I(L_L2)
.INC "..\Retry.net"

.END
